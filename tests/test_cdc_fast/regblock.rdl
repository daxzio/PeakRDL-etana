addrmap top {
    default regwidth = 32;
    default accesswidth = 32;

    // APB samples PRDATA on the falling edge, 5 ns after the rising edge that
    // issues the transfer. fast mode acks in that same cycle, so the destination
    // capture has to land inside that half-cycle: (cdc_nstages + 1) * 1 ns.
    signal { cdc_fast_mode_en = true; cdc_nstages = 2; } sync_clk;

    reg {
        cdc_clk = sync_clk;
        field { sw = rw; hw = r; } v[15:0] = 0xA5A5;
    } alpha @0x00;

    reg {
        cdc_clk = sync_clk;
        field { sw = rw; hw = r; } v[15:0] = 0x5A5A;
    } beta @0x04;
};
