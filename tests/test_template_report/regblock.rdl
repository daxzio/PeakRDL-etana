// Test case for template generation and hwif reporting

addrmap test_block {
    name = "Test Block for Template and Report";
    desc = "Simple test with input and output signals";

    reg status_reg {
        name = "Status Register";
        desc = "Status information from hardware";

        field {
            hw = w;
            sw = r;
            desc = "Ready flag";
        } ready[0:0];

        field {
            hw = w;
            sw = r;
            desc = "Error flag";
        } error[1:1];

        field {
            hw = w;
            sw = r;
            desc = "Status value";
        } status[15:8];
    } STATUS @ 0x0;

    reg control_reg {
        name = "Control Register";
        desc = "Control signals to hardware";

        field {
            hw = r;
            sw = rw;
            desc = "Enable control";
        } enable[0:0];

        field {
            hw = r;
            sw = rw;
            desc = "Mode selection";
        } mode[3:1];
    } CONTROL @ 0x4;

    reg data_reg {
        name = "Data Register";
        desc = "Bidirectional data";

        field {
            hw = rw;
            sw = rw;
            desc = "Data value";
        } value[7:0];
    } DATA @ 0x8;
};
