addrmap top {
    reg {
        field {
            sw=rw; hw=na;
        } f[31:0] = 0x0;
    } r1[32];
    external reg {
        field {
            sw=rw; hw=na;
        } f[31:0] = 0x0;
    } r2[32];
    external mem {
        memwidth = 32;
        mementries = 32;
    } r3;
};
