addrmap top #(
    longint N_REGS = 20,
    longint REGWIDTH = 32
) {
    reg reg_t {
        regwidth = REGWIDTH;
        field {sw=rw; hw=na;} f[REGWIDTH] = 1;
    };
    reg_t regs[N_REGS];
};
