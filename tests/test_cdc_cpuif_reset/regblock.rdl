addrmap top {
    default regwidth = 32;
    default accesswidth = 32;
    default sw = rw;
    default hw = na;

    signal {
        cpuif_reset;
        activehigh;
`ifdef CPUIF_RST_ASYNC
        async;
`else
        sync;
`endif
    } cpu_rst;

    signal {
`ifdef CDC_NSTAGES3
        cdc_nstages = 3;
`endif
`ifdef CDC_FAST_PROP
        cdc_fast_mode_en = true;
`endif
    } dom_clk;
    signal {
`ifdef CDC_NSTAGES3
        cdc_nstages = 3;
`endif
`ifdef CDC_FAST_PROP
        cdc_fast_mode_en = true;
`endif
    } oth_clk;

    reg {
        field { sw = rw; hw = r; } v[7:0] = 0x5A;
    } bus_cfg @0x00;

    reg {
        cdc_clk = dom_clk;
        field { sw = rw; hw = r; } v[7:0] = 0x10;
    } c0 @0x04;

    reg {
        cdc_clk = dom_clk;
        field { sw = rw; hw = r; } v[7:0] = 0x20;
    } c1 @0x08;

    reg {
        cdc_clk = dom_clk;
        field { sw = r; hw = w; } v[7:0];
    } s0 @0x0C;

    reg {
        cdc_clk = dom_clk;
        buffer_writes;
        field { sw = rw; hw = r; } v[7:0] = 0x30;
    } wtrg @0x10;

    reg {
        cdc_clk = dom_clk;
        buffer_writes;
        field { sw = rw; hw = r; } v[7:0] = 0x40;
    } wmem @0x14;
    wmem->wbuffer_trigger = wtrg;

    reg {
        cdc_clk = oth_clk;
        field { sw = rw; hw = r; } v[7:0] = 0x50;
    } o0 @0x18;

    reg {
        cdc_clk = oth_clk;
        field { sw = r; hw = w; } v[7:0];
    } os @0x1C;
};
