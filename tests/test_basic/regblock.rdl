addrmap top {
    reg {
        field {
            sw=rw; hw=na;
        } f[31:0] = 0x0;
    } r1[2];
};
