reg r_byte  {
    default sw = rw;
    default hw = na;
    desc = "
    ";
    field {
    } BYTE [8] = 0;
};
reg r_word  {
    default sw = rw;
    default hw = na;
    regwidth = 32;
    desc = "
    ";
    field {
    } WORD [16] = 0;
};

reg tout32_hwna {
    regwidth = 32;
    accesswidth = 32;
    default sw = rw;
    default hw = na;
    field {
    } UPPER [16] = 0;
    field {
    } LOWER [16] = 0;
};

reg tout32_hwr {
    regwidth = 32;
    accesswidth = 32;
    default sw = rw;
    default hw = r;
    field {
    } UPPER [16] = 0;
    field {
    } LOWER [16] = 0;
};

reg tout64_hwna {
    regwidth = 64;
    accesswidth = 32;
    default sw = rw;
    default hw = na;
    field {
    } UPPER [32] = 0;
    field {
    } LOWER [32] = 0;
};

reg tout64_hwr {
    regwidth = 64;
    accesswidth = 32;
    default sw = rw;
    default hw = r;
    field {
    } UPPER [32] = 0;
    field {
    } LOWER [32] = 0;
};

regfile page_config32_hwna {
    desc = "Contains all the registers that need to be maintained per page";

    tout32_hwna TOUT_MAX;
    tout32_hwna TOUT_MIN;
};

regfile page_config32_hwr {
    desc = "Contains all the registers that need to be maintained per page";

    tout32_hwr TOUT_MAX;
    tout32_hwr TOUT_MIN;
};

regfile page_config64_hwna {
    desc = "Contains all the registers that need to be maintained per page";

    tout64_hwna TOUT_MAX;
    tout64_hwna TOUT_MIN;
};

regfile page_config64_hwr {
    desc = "Contains all the registers that need to be maintained per page";

    tout64_hwr TOUT_MAX;
    tout64_hwr TOUT_MIN;
};

addrmap TBUS #(
    longint PAGES = 8
) {
    desc = "Register file containing TBUS registers";

    r_byte PAGE;
    PAGE->desc = "PAGE contains the Operating Memory (and at the option of the device manufacturer, User Store and Default Store) for each outpu";
    PAGE.BYTE->sw=r;

    r_byte OPERATON;
    r_byte CONFIG;

    page_config32_hwna PAGE_CONFIG32_HWNA[PAGES]@0x1000;

    page_config64_hwna PAGE_CONFIG64_HWNA[PAGES]@0x2000;
//     PAGE_CONFIG2.TOUT_MAX.FAULT_LIMIT->sw=r;

    tout32_hwna TOUT_MAX32_HWNA[PAGES]@0x3000;
    tout64_hwna TOUT_MAX64_HWNA[PAGES]@0x4000;

    page_config32_hwr PAGE_CONFIG32_HWNR[PAGES]@0x5000;
    page_config64_hwr PAGE_CONFIG64_HWNR[PAGES]@0x6000;

    tout32_hwr TOUT_MAX32_HWR[PAGES]@0x7000;
    tout64_hwr TOUT_MAX64_HWR[PAGES]@0x8000;

};
