addrmap top {
    default regwidth = 16;
    default accesswidth = 16;

    signal { cdc_nstages = 3; } sync_clk;

    reg {
        field { sw = rw; hw = r; } v[15:0] = 0xBEEF;
    } bus_cfg @0x00;

    reg {
        cdc_clk = sync_clk;
        field { sw = rw; hw = r; } v[15:0] = 0x1234;
    } cfg @0x04;

    reg {
        cdc_clk = sync_clk;
        field { sw = r; hw = w; } v[7:0] = 0;
    } sts @0x08;

    reg {
        cdc_clk = sync_clk;
        buffer_writes;
        field { sw = rw; hw = r; } v[11:0] = 0x100;
    } trg @0x0C;

    reg {
        cdc_clk = sync_clk;
        buffer_writes;
        field { sw = rw; hw = r; } v[11:0] = 0x200;
    } wmem @0x10;

    wmem->wbuffer_trigger = trg;
};
