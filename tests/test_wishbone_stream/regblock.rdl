addrmap top {
    default regwidth = 32;
    default accesswidth = 32;

    reg {
        field { sw = rw; hw = r; } f[31:0] = 0;
    } r0 @0x0;

    reg {
        field { sw = rw; hw = r; } f[31:0] = 0;
    } r1 @0x4;
};
