addrmap refused_wide_multifield {
    external reg {
        regwidth = 64;
        accesswidth = 32;
        field { sw = rw; hw = r; } a[7:0] = 0;
        field { sw = rw; hw = r; } b[47:40] = 0;
    } wide2;
};
