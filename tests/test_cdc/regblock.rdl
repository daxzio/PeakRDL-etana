addrmap top {
    default regwidth = 32;
    default accesswidth = 32;
    default sw = rw;
    default hw = na;

    signal {
`ifdef CDC_NSTAGES3
        cdc_nstages = 3;
`endif
`ifdef CDC_FAST_PROP
        cdc_fast_mode_en = true;
`endif
    } sync_clk_slow;
    signal {
`ifdef CDC_NSTAGES3
        cdc_nstages = 3;
`endif
`ifdef CDC_FAST_PROP
        cdc_fast_mode_en = true;
`endif
    } sync_clk_fast;

    reg {
        cdc_clk = sync_clk_slow;
        field { sw = rw; hw = r; } gain[7:0] = 0x49;
    } lane_cfg @0x00;

    reg {
        cdc_clk = sync_clk_slow;
        field { sw = r; hw = w; } live[7:0] = 0x82;
    } lane_sts @0x04;

    reg {
        cdc_clk = sync_clk_fast;
        field { sw = rw; hw = r; } cfg[15:0] = 0x364;
    } fast_cfg @0x08;

    reg {
        cdc_clk = sync_clk_fast;
        field { sw = r; hw = w; } sts[15:0] = 0x527;
    } fast_sts @0x0c;

    reg {
        regwidth = 8;
        accesswidth = 8;
        cdc_clk = sync_clk_slow;
        field { sw = rw; hw = r; } v[7:0] = 0x5C;
    } cfg8 @0x10;

    reg {
        regwidth = 16;
        accesswidth = 16;
        cdc_clk = sync_clk_slow;
        field { sw = rw; hw = r; } v[15:0] = 0xA5C3;
    } cfg16 @0x14;

    reg {
        cdc_clk = sync_clk_slow;
        field { sw = rw; hw = r; } v[31:0] = 0x89ABCDEF;
    } cfg32 @0x18;

    reg {
        cdc_clk = sync_clk_slow;
        field { sw = rw; hw = r; } a[0:0] = 1;
        field { sw = rw; hw = r; } b[6:4] = 5;
        field { sw = rw; hw = r; } c[15:9] = 0x2A;
    } pos_cfg @0x1C;

    reg {
        cdc_clk = sync_clk_slow;
        field { sw = r; hw = w; } s0[3:0] = 0;
        field { sw = r; hw = w; } s1[11:8] = 0;
    } pos_sts @0x20;

    reg {
        cdc_clk = sync_clk_fast;
        field { sw = w; hw = r; } v[11:0] = 0x123;
    } wo_cfg @0x24;

    reg {
        cdc_clk = sync_clk_fast;
        field { sw = rw; hw = r; } v[7:0];
    } noreset_cfg @0x28;

    reg {
        field { sw = rw; hw = r; } v[31:0] = 0x600DF00D;
    } bus_cfg @0x2C;

    reg {
        cdc_clk = sync_clk_slow;
        buffer_writes;
        field { sw = rw; hw = r; } v[7:0] = 0x11;
    } mix_trg @0x30;

    // Write members with unused bits, and fields with and without a reset value. The
    // field without one is write-only, so that no bus read returns X.
    reg {
        cdc_clk = sync_clk_slow;
        buffer_writes;
        field { sw = rw; hw = r; } v[11:0] = 0x222;
        field { sw = w; hw = r; } nr[23:20];
    } mix_mem[2] @0x34 += 0x4;

    mix_mem->wbuffer_trigger = mix_trg;

    // A write member narrower than the bus.
    reg {
        regwidth = 16;
        accesswidth = 16;
        cdc_clk = sync_clk_slow;
        buffer_writes;
        field { sw = rw; hw = r; } v[9:0] = 0x3F;
    } nar_mem @0x3C;

    nar_mem->wbuffer_trigger = mix_trg;
};
