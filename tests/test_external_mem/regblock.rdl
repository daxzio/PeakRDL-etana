addrmap regblock {
    default regwidth = 32;
//     reg {
//         field {
//             sw=r; hw=w;
//         } version[32] = 0;
//     } version;
//     reg {
//         field {
//             sw=r; hw=w;
//         } design[32] = 0;
//     } design;
    reg {
        field {
            sw=r; hw=w;
        } clock_frequency[32] = 0;
    } clock_frequency;

    reg {
        field {
            sw=rw; hw=na;
        } scratch[32] = 0;
    } scratch @0x10;

    reg {
//         accesswidth = 64;
        field {
            sw=rw; hw=na;
        } scratch2[16] = 0;
    } scratch2 @0x20;

    external mem  {
        name = "bram";

        mementries = 1024;
        memwidth = 32;
        sw = r;
    } bram @0x1000;

    external mem  {
        name = "bram2";

        mementries = 1024;
        memwidth = 32;
        sw = rw;
    } bram2  @0x2000;

    external mem  {
        name = "bram2";

        mementries = 1024;
        memwidth = 32;
        sw = rw;
    } bram3  @0x4000;
//     reg {
//         field {
//             sw=r; hw=w;
//         } num_hulks[16] = 0;
//     } num_hulks;
//     reg {
//         field {
//             sw=rw; hw=r;
//         } active_hulks[16] = 0;
//     } active_hulks;
//     reg {
//         field {
//             sw=w; hw=r;
// // 			singlepulse;
//         } iprog[1] = 0;
//     } iprog;
//     reg {
//         field {
//             sw=rw; hw=r;
//         } wbstar[32] = 0;
//     } wbstar;
//     reg {
//         field {
//             sw=r; hw=w;
//         } icape_out[32] = 0;
//     } icape_out;
//     reg {
//         field {
//             sw=rw; hw=r;
//         } spi_select[4] = 0;
//     } spi_select;


};
