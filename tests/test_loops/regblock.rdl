addrmap top {
    reg {
        field {
            sw=rw; hw=na;
        } f[32] = 0x11;
    } r1[1024];
};
