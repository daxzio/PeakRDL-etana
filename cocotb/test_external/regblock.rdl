addrmap top {
    reg my_reg {
        field {sw=r; hw=w;} whatever[30] = 0;
    };
    reg my_rex {
        field {sw=r; hw=rw;} whateverx[32] = 0;
    };
    reg my_rew {
        field {sw=rw; hw=r;} whateverw[32] = 0;
    };
    reg my_rez {
        field {sw=w; hw=r;} whateverw[32] = 0;
    };
    reg my_rea {
        field {sw=r; hw=w;} whatever_a[7:4] = 0;
        field {sw=w; hw=r;} whatever_b[23:16] = 0;
        field {sw=rw; hw=r;} whatever_c[31:27] = 0;
    };
    reg my_reg_alt {
        field {sw=r; hw=w;} whatever_a[3:2] = 0;
        field {sw=w; hw=r;} whatever_b[4:4] = 0;
        field {sw=rw; hw=r;} whatever_c[15:8] = 0;
    };
    reg my_wide_reg {
        regwidth = 64;
        accesswidth = 32;
        field {sw=rw; hw=r;} whatever = 0;
    };
    external my_reg ext_reg @ 0x00;
    external my_reg ext_ret @ 0x04;
    external my_rex ext_rex @ 0x08;
    external my_rew ext_rew @ 0x0c;
    external my_rez ext_rez @ 0x10;
    external my_rea ext_rea @ 0x14;

    external my_reg ext_reg_array[64] @ 0x100;
    external my_rea ext_rea_array[8] @ 0x200;
//     external my_reg ext_reg_array[32] @ 0x100 += 4;

//     external my_reg_alt ext_reg @ 0x00;
//     my_reg int_reg @ 0x04;
    external my_wide_reg wide_ext_reg @ 0x300;
    external my_wide_reg wide_ext_reg_array[8] @ 0x400;
//     external my_reg ext_reg_array[32] @ 0x400 += 4;


    external regfile {
        my_reg placeholder @ 8*4-4;
    } rf @ 0x1000;
    external regfile {
        my_rea flaceholdet @ 8*4-4;
    } rx @ 0x2000;
//     external regfile {
//         my_wide_reg xxaceholdet @ 8*4-4;
//     } wrx @ 0x3000;

    external mem {
        memwidth = 32;
        mementries = 8;
    } mm @ 0x4000;

//     reg my_ro_reg {
//         field {sw=r; hw=w;} whatever[32] = 0;
//     };
//     reg my_wo_reg {
//         field {sw=w; hw=r;} whatever[32] = 0;
//     };
//     external my_ro_reg ro_reg @ 0x5000;
//     external my_wo_reg wo_reg @ 0x5004;
// 
//     reg my_wide_ro_reg {
//         regwidth = 64;
//         accesswidth = 32;
//         field {sw=r; hw=w;} whatever[32] = 0;
//     };
//     reg my_wide_wo_reg {
//         regwidth = 64;
//         accesswidth = 32;
//         field {sw=w; hw=r;} whatever[32] = 0;
//     };
//     external my_wide_ro_reg wide_ro_reg @ 0x5010;
//     external my_wide_wo_reg wide_wo_reg @ 0x5018;
//     addrmap {
//         my_reg rraceholder @ 8*4-4;
//     } am @ 0x3000;

};
